RC low-pass filter — ngspice batch smoke fixture
V1 in 0 PULSE(0 1 0 1n 1n 50n 100n)
R1 in out 1k
C1 out 0 1n
.tran 1n 200n
.control
run
wrdata rc_out.txt v(out)
quit
.endc
.end
